* SPICE NETLIST
***************************************

.SUBCKT n12_mis_ckt D G S B
.ENDS
***************************************
.SUBCKT p12_mis_ckt D G S B
.ENDS
***************************************
.SUBCKT n33_mis_ckt D G S B
.ENDS
***************************************
.SUBCKT p33_mis_ckt D G S B
.ENDS
***************************************
.SUBCKT dnw12_ckt D G S B1 T B2
.ENDS
***************************************
.SUBCKT dnwlvt12_ckt D G S B1 T B2
.ENDS
***************************************
.SUBCKT dnwhvt12_ckt D G S B1 T B2
.ENDS
***************************************
.SUBCKT dnw33_ckt D G S B1 T B2
.ENDS
***************************************
.SUBCKT dnw12_4t_ckt D G S B
.ENDS
***************************************
.SUBCKT dnwlvt12_4t_ckt D G S B
.ENDS
***************************************
.SUBCKT dnwhvt12_4t_ckt D G S B
.ENDS
***************************************
.SUBCKT dnw33_4t_ckt D G S B
.ENDS
***************************************
.SUBCKT pvar12_ckt PLUS MINUS
.ENDS
***************************************
.SUBCKT pvar33_ckt PLUS MINUS
.ENDS
***************************************
.SUBCKT rnwaa_ckt PLUS MINUS B
.ENDS
***************************************
.SUBCKT rnwsti_ckt PLUS MINUS B
.ENDS
***************************************
.SUBCKT rpdif_ckt PLUS MINUS B
.ENDS
***************************************
.SUBCKT rndif_ckt PLUS MINUS B
.ENDS
***************************************
.SUBCKT rppo_ckt PLUS MINUS
.ENDS
***************************************
.SUBCKT rppo_3t_ckt PLUS MINUS B
.ENDS
***************************************
.SUBCKT rnpo_ckt PLUS MINUS
.ENDS
***************************************
.SUBCKT rnpo_3t_ckt PLUS MINUS B
.ENDS
***************************************
.SUBCKT rpdifsab_ckt PLUS MINUS B
.ENDS
***************************************
.SUBCKT rndifsab_ckt PLUS MINUS B
.ENDS
***************************************
.SUBCKT rpposab_ckt PLUS MINUS
.ENDS
***************************************
.SUBCKT rpposab_3t_ckt PLUS MINUS B
.ENDS
***************************************
.SUBCKT rnposab_ckt PLUS MINUS
.ENDS
***************************************
.SUBCKT rnposab_3t_ckt PLUS MINUS B
.ENDS
***************************************
.SUBCKT rhrpo_ckt PLUS MINUS
.ENDS
***************************************
.SUBCKT rhrpo_3t_ckt PLUS MINUS B
.ENDS
***************************************
.SUBCKT ralpa_ckt PLUS MINUS B
.ENDS
***************************************
.SUBCKT rm1_ckt PLUS MINUS B
.ENDS
***************************************
.SUBCKT rm2_ckt PLUS MINUS B
.ENDS
***************************************
.SUBCKT rm3_ckt PLUS MINUS B
.ENDS
***************************************
.SUBCKT rm4_ckt PLUS MINUS B
.ENDS
***************************************
.SUBCKT rm5_ckt PLUS MINUS B
.ENDS
***************************************
.SUBCKT rm8_ckt PLUS MINUS B
.ENDS
***************************************
.SUBCKT ralpa_rf PLUS MINUS B
.ENDS
***************************************
.SUBCKT rtm2_rf PLUS MINUS B
.ENDS
***************************************
.SUBCKT mim3_ckt PLUS MINUS
.ENDS
***************************************
.SUBCKT n12_ckt_rf D G S B
.ENDS
***************************************
.SUBCKT dnw12_ckt_rf D G S B
.ENDS
***************************************
.SUBCKT p12_ckt_rf D G S B
.ENDS
***************************************
.SUBCKT n33_ckt_rf D G S B
.ENDS
***************************************
.SUBCKT dnw33_ckt_rf D G S B
.ENDS
***************************************
.SUBCKT p33_ckt_rf D G S B
.ENDS
***************************************
.SUBCKT pvar12_ckt_rf PLUS MINUS
.ENDS
***************************************
.SUBCKT pvar33_ckt_rf PLUS MINUS
.ENDS
***************************************
.SUBCKT pvardio12_ckt_rf PLUS MINUS
.ENDS
***************************************
.SUBCKT pvardio33_ckt_rf PLUS MINUS
.ENDS
***************************************
.SUBCKT rndifsab_ckt_rf PLUS MINUS B
.ENDS
***************************************
.SUBCKT rpdifsab_ckt_rf PLUS MINUS B
.ENDS
***************************************
.SUBCKT rnposab_ckt_rf PLUS MINUS
.ENDS
***************************************
.SUBCKT rpposab_ckt_rf PLUS MINUS
.ENDS
***************************************
.SUBCKT rhrpo_ckt_rf PLUS MINUS
.ENDS
***************************************
.SUBCKT rnposab_ckt_rf_3t PLUS MINUS B
.ENDS
***************************************
.SUBCKT rpposab_ckt_rf_3t PLUS MINUS B
.ENDS
***************************************
.SUBCKT rhrpo_ckt_rf_3t PLUS MINUS B
.ENDS
***************************************
.SUBCKT ind_rf_t1d5 PLUS MINUS
.ENDS
***************************************
.SUBCKT ind_rf_t2 PLUS MINUS
.ENDS
***************************************
.SUBCKT ind_rf_t2d5 PLUS MINUS
.ENDS
***************************************
.SUBCKT ind_rf_t3 PLUS MINUS
.ENDS
***************************************
.SUBCKT ind_rf_t3d5 PLUS MINUS
.ENDS
***************************************
.SUBCKT ind_rf_t4 PLUS MINUS
.ENDS
***************************************
.SUBCKT ind_rf_t4d5 PLUS MINUS
.ENDS
***************************************
.SUBCKT ind_rf_t5 PLUS MINUS
.ENDS
***************************************
.SUBCKT ind_rf_t5d5 PLUS MINUS
.ENDS
***************************************
.SUBCKT ind_rf_t6 PLUS MINUS
.ENDS
***************************************
.SUBCKT ind_rf_t6d5 PLUS MINUS
.ENDS
***************************************
.SUBCKT diff_ind_rf PLUS MINUS
.ENDS
***************************************
.SUBCKT diff_ind_3t_rf PLUS MINUS B
.ENDS
***************************************
.SUBCKT diff_ind_3t_alpa_rf PLUS MINUS B
.ENDS
***************************************
.SUBCKT ind_rf_psub_t1d5 PLUS MINUS B
.ENDS
***************************************
.SUBCKT ind_rf_psub_t2 PLUS MINUS B
.ENDS
***************************************
.SUBCKT ind_rf_psub_t2d5 PLUS MINUS B
.ENDS
***************************************
.SUBCKT ind_rf_psub_t3 PLUS MINUS B
.ENDS
***************************************
.SUBCKT ind_rf_psub_t3d5 PLUS MINUS B
.ENDS
***************************************
.SUBCKT ind_rf_psub_t4 PLUS MINUS B
.ENDS
***************************************
.SUBCKT ind_rf_psub_t4d5 PLUS MINUS B
.ENDS
***************************************
.SUBCKT ind_rf_psub_t5 PLUS MINUS B
.ENDS
***************************************
.SUBCKT ind_rf_psub_t5d5 PLUS MINUS B
.ENDS
***************************************
.SUBCKT ind_rf_psub_t6 PLUS MINUS B
.ENDS
***************************************
.SUBCKT ind_rf_psub_t6d5 PLUS MINUS B
.ENDS
***************************************
.SUBCKT diff_ind_rf_psub PLUS MINUS B
.ENDS
***************************************
.SUBCKT diff_ind_3t_rf_psub PLUS MINUS B1 B2
.ENDS
***************************************
.SUBCKT diff_ind_3t_alpa_rf_psub PLUS MINUS B1 B2
.ENDS
***************************************
.SUBCKT ind_rf_pgs_t1d5 PLUS MINUS
.ENDS
***************************************
.SUBCKT ind_rf_pgs_t2 PLUS MINUS
.ENDS
***************************************
.SUBCKT ind_rf_pgs_t2d5 PLUS MINUS
.ENDS
***************************************
.SUBCKT ind_rf_pgs_t3 PLUS MINUS
.ENDS
***************************************
.SUBCKT ind_rf_pgs_t3d5 PLUS MINUS
.ENDS
***************************************
.SUBCKT ind_rf_pgs_t4 PLUS MINUS
.ENDS
***************************************
.SUBCKT ind_rf_pgs_t4d5 PLUS MINUS
.ENDS
***************************************
.SUBCKT ind_rf_pgs_t5 PLUS MINUS
.ENDS
***************************************
.SUBCKT ind_rf_pgs_t5d5 PLUS MINUS
.ENDS
***************************************
.SUBCKT ind_rf_pgs_t6 PLUS MINUS
.ENDS
***************************************
.SUBCKT ind_rf_pgs_t6d5 PLUS MINUS
.ENDS
***************************************
.SUBCKT diff_ind_rf_pgs PLUS MINUS
.ENDS
***************************************
.SUBCKT diff_ind_3t_rf_pgs_t1d5 PLUS MINUS B
.ENDS
***************************************
.SUBCKT diff_ind_3t_rf_pgs_t2 PLUS MINUS B
.ENDS
***************************************
.SUBCKT diff_ind_3t_rf_pgs_t2d5 PLUS MINUS B
.ENDS
***************************************
.SUBCKT diff_ind_3t_rf_pgs_t3 PLUS MINUS B
.ENDS
***************************************
.SUBCKT diff_ind_3t_rf_pgs_t3d5 PLUS MINUS B
.ENDS
***************************************
.SUBCKT diff_ind_3t_rf_pgs_t4 PLUS MINUS B
.ENDS
***************************************
.SUBCKT diff_ind_3t_rf_pgs_t4d5 PLUS MINUS B
.ENDS
***************************************
.SUBCKT diff_ind_3t_rf_pgs_t5 PLUS MINUS B
.ENDS
***************************************
.SUBCKT diff_ind_3t_rf_pgs_t5d5 PLUS MINUS B
.ENDS
***************************************
.SUBCKT diff_ind_3t_rf_pgs_t6 PLUS MINUS B
.ENDS
***************************************
.SUBCKT diff_ind_3t_rf_pgs_t6d5 PLUS MINUS B
.ENDS
***************************************
.SUBCKT ind_rf_pgs_psub_t1d5 PLUS MINUS B
.ENDS
***************************************
.SUBCKT ind_rf_pgs_psub_t2 PLUS MINUS B
.ENDS
***************************************
.SUBCKT ind_rf_pgs_psub_t2d5 PLUS MINUS B
.ENDS
***************************************
.SUBCKT ind_rf_pgs_psub_t3 PLUS MINUS B
.ENDS
***************************************
.SUBCKT ind_rf_pgs_psub_t3d5 PLUS MINUS B
.ENDS
***************************************
.SUBCKT ind_rf_pgs_psub_t4 PLUS MINUS B
.ENDS
***************************************
.SUBCKT ind_rf_pgs_psub_t4d5 PLUS MINUS B
.ENDS
***************************************
.SUBCKT ind_rf_pgs_psub_t5 PLUS MINUS B
.ENDS
***************************************
.SUBCKT ind_rf_pgs_psub_t5d5 PLUS MINUS B
.ENDS
***************************************
.SUBCKT ind_rf_pgs_psub_t6 PLUS MINUS B
.ENDS
***************************************
.SUBCKT ind_rf_pgs_psub_t6d5 PLUS MINUS B
.ENDS
***************************************
.SUBCKT diff_ind_rf_pgs_psub PLUS MINUS B
.ENDS
***************************************
.SUBCKT diff_ind_3t_rf_pgs_psub_t1d5 PLUS MINUS B1 B2
.ENDS
***************************************
.SUBCKT diff_ind_3t_rf_pgs_psub_t2 PLUS MINUS B1 B2
.ENDS
***************************************
.SUBCKT diff_ind_3t_rf_pgs_psub_t2d5 PLUS MINUS B1 B2
.ENDS
***************************************
.SUBCKT diff_ind_3t_rf_pgs_psub_t3 PLUS MINUS B1 B2
.ENDS
***************************************
.SUBCKT diff_ind_3t_rf_pgs_psub_t3d5 PLUS MINUS B1 B2
.ENDS
***************************************
.SUBCKT diff_ind_3t_rf_pgs_psub_t4 PLUS MINUS B1 B2
.ENDS
***************************************
.SUBCKT diff_ind_3t_rf_pgs_psub_t4d5 PLUS MINUS B1 B2
.ENDS
***************************************
.SUBCKT diff_ind_3t_rf_pgs_psub_t5 PLUS MINUS B1 B2
.ENDS
***************************************
.SUBCKT diff_ind_3t_rf_pgs_psub_t5d5 PLUS MINUS B1 B2
.ENDS
***************************************
.SUBCKT diff_ind_3t_rf_pgs_psub_t6 PLUS MINUS B1 B2
.ENDS
***************************************
.SUBCKT diff_ind_3t_rf_pgs_psub_t6d5 PLUS MINUS B1 B2
.ENDS
***************************************
.SUBCKT spi_ind_rf_1p2 PLUS MINUS
.ENDS
***************************************
.SUBCKT spi_ind_rf_1p3 PLUS MINUS
.ENDS
***************************************
.SUBCKT spi_ind_rf_psub_1p2 PLUS MINUS B
.ENDS
***************************************
.SUBCKT spi_ind_rf_psub_1p3 PLUS MINUS B
.ENDS
***************************************
.SUBCKT rf_3Tdiff_1talpa_t1 PLUS MINUS B
.ENDS
***************************************
.SUBCKT rf_3Tdiff_1talpa_t2 PLUS MINUS B
.ENDS
***************************************
.SUBCKT rf_3Tdiff_1talpa_t3 PLUS MINUS B
.ENDS
***************************************
.SUBCKT rf_3Tdiff_1talpa_t4 PLUS MINUS B
.ENDS
***************************************
.SUBCKT rf_3Tdiff_1talpa_t5 PLUS MINUS B
.ENDS
***************************************
.SUBCKT rf_3Tdiff_1talpa_t6 PLUS MINUS B
.ENDS
***************************************
.SUBCKT rf_3Tdiff_1talpa_t7 PLUS MINUS B
.ENDS
***************************************
.SUBCKT rf_3Tdiff_1talpa_psub_t1 PLUS MINUS B1 B2
.ENDS
***************************************
.SUBCKT rf_3Tdiff_1talpa_psub_t2 PLUS MINUS B1 B2
.ENDS
***************************************
.SUBCKT rf_3Tdiff_1talpa_psub_t3 PLUS MINUS B1 B2
.ENDS
***************************************
.SUBCKT rf_3Tdiff_1talpa_psub_t4 PLUS MINUS B1 B2
.ENDS
***************************************
.SUBCKT rf_3Tdiff_1talpa_psub_t5 PLUS MINUS B1 B2
.ENDS
***************************************
.SUBCKT rf_3Tdiff_1talpa_psub_t6 PLUS MINUS B1 B2
.ENDS
***************************************
.SUBCKT rf_3Tdiff_1talpa_psub_t7 PLUS MINUS B1 B2
.ENDS
***************************************
.SUBCKT mim3_rf PLUS MINUS
.ENDS
***************************************
.SUBCKT mom13_ckt PLUS MINUS
.ENDS
***************************************
.SUBCKT mom_ckt_rf PLUS MINUS
.ENDS
***************************************
.SUBCKT mom_wips_ckt_rf PLUS MINUS
.ENDS
***************************************
.SUBCKT mom_ckt_rf_3t PLUS MINUS B
.ENDS
***************************************
.SUBCKT mom_wips_ckt_rf_3t PLUS MINUS B
.ENDS
***************************************
.SUBCKT mom14_ckt PLUS MINUS
.ENDS
***************************************
.SUBCKT mom15_ckt PLUS MINUS
.ENDS
***************************************
.SUBCKT mom24_ckt PLUS MINUS
.ENDS
***************************************
.SUBCKT mom25_ckt PLUS MINUS
.ENDS
***************************************
.SUBCKT mom35_ckt PLUS MINUS
.ENDS
***************************************
.SUBCKT inv GND VDD Y A
** N=4 EP=4 IP=0 FDC=3
M0 Y A GND GND n12 L=1.3e-07 W=5.4e-07 AD=1.782e-13 AS=1.782e-13 PD=1.74e-06 PS=1.74e-06 NRD=0.611111 NRS=0.611111 sa=3.3e-07 sb=3.3e-07 m=1 fw=5.4e-07 $X=1130 $Y=-4890 $D=0
M1 Y A VDD VDD p12 L=1.3e-07 W=1.3e-06 AD=4.29e-13 AS=4.29e-13 PD=3.26e-06 PS=3.26e-06 NRD=0.253846 NRS=0.253846 sa=3.3e-07 sb=3.3e-07 m=1 fw=1.3e-06 $X=1130 $Y=-2650 $D=6
D2 GND VDD parasitic_nwd AREA=3.4611e-12 PJ=7.76e-06 m=1 $X=500 $Y=-2950 $D=277
.ENDS
***************************************
